[IBIS ver]   4.0
[File name]   43_46tr16256-85120bl.ibs
[File Rev]   1.0
[Date]   May, 17, 2018
[Source]   ISSI
[Notes]   Revision History:
[Disclaimer] Data is for modeling purpose only
[Copyright] Copyright 2011 ISSI inc.
|   Component 43_46tr16256bl
[Component]   43_46tr16256bl
|[Package Model] 43_46tr16256bl_pkg(x16)
[Manufacturer]   ISSI
[Package]
|   typ   min   max
R_pkg   1146.1m   270.7m   1520.3m
L_pkg   1.87nH   0.63nH   2.55nH
C_pkg   0.55pF   0.31pF   0.80pF
[Pin]   signal_name   model_name   R_pin   L_pin   C_pin
A1   VDDQ   POWER
A2   DQU5   I/O   1434.38m   2.225nH   0.667pF
A3   DQU7   I/O   1366.54m   2.220nH   0.612pF
A7   DQU4   I/O   1232.72m   1.751nH   0.587pF
A8   VDDQ   POWER
A9   VSS   GND
B1   VSSQ   GND
B2   VDD   POWER
B3   VSS   GND
B7   DQSUB   I/O   1252.90m   1.897nH   0.560pF
B8   DQU6   I/O   1268.48m   1.605nH   0.641pF
B9   VSSQ   GND
C1   VDDQ   POWER
C2   DQU3   I/O   1354.27m   1.826nH   0.636pF
C3   DQU1   I/O   1319.81m   2.094nH   0.611pF
C7   DQSU   I/O   1220.10m   1.868nH   0.596pF
C8   DQU2   I/O   1207.72m   1.689nH   0.548pF
C9   VDDQ   POWER
D1   VSSQ   GND
D2   VDDQ   POWER
D3   DMU   DM   1086.57m   1.546nH   0.458pF
D7   DQU0   I/O   1111.20m   1.707nH   0.443pF
D8   VSSQ   GND
D9   VDD   POWER
E1   VSS   GND
E2   VSSQ   GND
E3   DQL0   I/O   1102.42m   1.597nH   0.480pF
E7   DML   DM   1149.70m   1.725nH   0.464pF
E8   VSSQ   GND
E9   VDDQ   POWER
F1   VDDQ   POWER
F2   DQL2   I/O   1254.87m   1.590nH   0.623pF
F3   DQSL   I/O   1021.10m   1.606nH   0.452pF
F7   DQL1   I/O   1100.26m   1.691nH   0.438pF
F8   DQL3   I/O   1199.31m   1.806nH   0.575pF
F9   VSSQ   GND
G1   VSSQ   GND
G2   DQL6   I/O   1142.33m   1.757nH   0.552pF
G3   DQSLB   I/O   1068.09m   1.679nH   0.377pF
G7   VDD   POWER
G8   VSS   GND
G9   VSSQ   GND
H1   VREFDQ   POWER
H2   VDDQ   POWER
H3   DQL4   I/O   1017.09m   1.642nH   0.413pF
H7   DQL7   I/O   1048.02m   1.790nH   0.426pF
H8   DQL5   I/O   1208.86m   1.857nH   0.546pF
H9   VDDQ   POWER
J1   NC   NC
J2   VSS   GND
J3   RASB   RECEIVER   989.87m   1.559nH   0.445pF
J7   CK   CLKRCV   286.07m   0.727nH   0.318pF
J8   VSS   GND
J9   NC   NC
K1   ODT   RECEIVER   1142.72m   1.885nH   0.583pF
K2   VDD   POWER
K3   CASB   RECEIVER   925.43m   1.520nH   0.408pF
K7   CKB   CLKRCV   270.70m   0.635nH   0.327pF
K8   VDD   POWER
K9   CKE   RECEIVER   1265.16m   2.206nH   0.600pF
L1   NC   NC
L2   CSB   RECEIVER   1140.85m   1.859nH   0.583pF
L3   WEB   RECEIVER   988.32m   1.604nH   0.438pF
L7   A10   RECEIVER   1031.10m   1.805nH   0.440pF
L8   ZQ   RECEIVER   467.67m   1.482nH   0.710pF
L9   NC   NC
M1   VSS   GND
M2   BA0   RECEIVER   1199.70m   1.620nH   0.598pF
M3   BA2   RECEIVER   990.43m   1.711nH   0.449pF
M7   NC   NC
M8   VREFCA   POWER
M9   VSS   GND
N1   VDD   POWER
N2   A3   RECEIVER   1315.69m   2.148nH   0.638pF
N3   A0   RECEIVER   1075.12m   1.789nH   0.464pF
N7   A12   RECEIVER   1112.79m   2.132nH   0.553pF
N8   BA1   RECEIVER   1129.61m   2.169nH   0.567pF
N9   VDD   POWER
P1   VSS   GND
P2   A5   RECEIVER   1403.79m   2.436nH   0.671pF
P3   A2   RECEIVER   1164.34m   2.137nH   0.563pF
P7   A1   RECEIVER   1228.30m   2.298nH   0.587pF
P8   A4   RECEIVER   1391.04m   2.551nH   0.652pF
P9   VSS   GND
R1   VDD   POWER
R2   A7   RECEIVER   1196.78m   2.131nH   0.606pF
R3   A9   RECEIVER   1352.96m   2.338nH   0.646pF
R7   A11   RECEIVER   1303.65m   2.366nH   0.639pF
R8   A6   RECEIVER   1421.49m   2.471nH   0.676pF
R9   VDD   POWER
T1   VSS   GND
T2   RESETB   RECEIVER   1044.60m   2.101nH   0.805pF
T3   A13   RECEIVER   1434.95m   2.259nH   0.676pF
T7   A14   RECEIVER   1390.10m   2.222nH   0.636pF
T8   A8   RECEIVER   1520.36m   2.511nH   0.714pF
T9   VSS   GND
|**********************DIFF PIN*********************************************
[Diff_pin]   inv_pin   vdiff   tdelay_typ   tdelay_min   tdelay_max
   F3   G3   0.400V   0ns   NA   NA
   C7   B7   0.400V   0ns   NA   NA
   J7   K7   0.400V   0ns   NA   NA
|   Component 43_46tr85120bl
[Component]   43_46tr85120bl
|[Package Model]  43_46tr85120bl_pkg(x8)
[Manufacturer]   ISSI
[Package]
|   typ   min   max
R_pkg   1145.3m   394.68m   1411.4m
L_pkg   1.64nH   0.682nH   2.214nH
C_pkg   0.548pF   0.328pF   0.846pF
[Pin]   signal_name   model_name   R_pin   L_pin   C_pin
A1   VSS   GND
A2   VDD   POWER
A3   NC   NC
A7   TDQSB   RECEIVER   1184.62m   1.426nH   0.545pF
A8   VSS   GND
A9   VDD   POWER
B1   VSS   GND
B2   VSSQ   GND
B3   DQ0   I/O   1210.07m   1.467nH   0.550pF
B7   DM   DM   1241.42m   1.585nH   0.552pF
B8   VSSQ   GND
B9   VDDQ   POWER
C1   VDDQ   POWER
C2   DQ2   I/O   1267.21m   1.642nH   0.584pF
C3   DQS   I/O   1159.20m   1.768nH   0.553pF
C7   DQ1   I/O   1192.52m   1.583nH   0.544pF
C8   DQ3   I/O   1206.41m   1.422nH   0.571pF
C9   VSSQ   GND
D1   VSSQ   GND
D2   DQ6   I/O   1203.14m   1.345nH   0.562pF
D3   DQSB   I/O   1239.16m   1.766nH   0.565pF
D7   VDD   POWER
D8   VSS   GND
D9   VSSQ   GND
E1   VREFDQ   POWER
E2   VDDQ   POWER
E3   DQ4   I/O   1152.25m   1.531nH   0.518pF
E7   DQ7   I/O   1081.65m   1.405nH   0.487pF
E8   DQ5   I/O   1187.44m   1.478nH   0.552pF
E9   VDDQ   POWER
F1   NC   NC
F2   VSS   GND
F3   RASB   RECEIVER   976.61m   1.479nH   0.480pF
F7   CK   CLKRCV   394.68m   0.716nH   0.330pF
F8   VSS   GND
F9   NC   NC
G1   ODT   RECEIVER   1082.84m   1.730nH   0.524pF
G2   VDD   POWER
G3   CASB   RECEIVER   943.90m   1.397nH   0.474pF
G7   CKB   CLKRCV   407.64m   0.682nH   0.328pF
G8   VDD   POWER
G9   CKE   RECEIVER   1028.33m   1.564nH   0.508pF
H1   NC   NC
H2   CSB   RECEIVER   978.55m   1.536nH   0.493pF
H3   WEB   RECEIVER   866.32m   1.392nH   0.400pF
H7   A10   RECEIVER   1201.46m   1.684nH   0.525pF
H8   ZQ   RECEIVER   647.23m   1.507nH   0.846pF
H9   NC   NC
J1   VSS   GND
J2   BA0   RECEIVER   1064.71m   1.332nH   0.510pF
J3   BA2   RECEIVER   964.50m   1.391nH   0.476pF
J7   A15   RECEIVER   1285.34m   1.768nH   0.571pF
J8   VREFCA   POWER
J9   VSS   GND
K1   VDD   POWER
K2   A3   RECEIVER   1345.01m   1.789nH   0.601pF
K3   A0   RECEIVER   1275.34m   1.899nH   0.560pF
K7   A12   RECEIVER   1185.30m   1.872nH   0.473pF
K8   BA1   RECEIVER   1013.67m   1.452nH   0.486pF
K9   VDD   POWER
L1   VSS   GND
L2   A5   RECEIVER   1319.93m   2.054nH   0.564pF
L3   A2   RECEIVER   1360.13m   2.089nH   0.602pF
L7   A1   RECEIVER   1264.31m   1.849nH   0.588pF
L8   A4   RECEIVER   1367.70m   1.708nH   0.605pF
L9   VSS   GND
M1   VDD   POWER
M2   A7   RECEIVER   1402.67m   2.196nH   0.625pF
M3   A9   RECEIVER   1401.84m   2.105nH   0.611pF
M7   A11   RECEIVER   1354.64m   2.131nH   0.601pF
M8   A6   RECEIVER   1404.69m   2.077nH   0.611pF
M9   VDD   POWER
N1   VSS   GND
N2   RESETB   RECEIVER   888.91m   1.528nH   0.697pF
N3   A13   RECEIVER   1399.83m   1.933nH   0.607pF
N7   A14   RECEIVER   1411.46m   2.025nH   0.611pF
N8   A8   RECEIVER   1396.59m   2.214nH   0.618pF
N9   VSS   GND
|**********************DIFF PIN*********************************************
[Diff_pin]   inv_pin   vdiff   tdelay_typ   tdelay_min   tdelay_max
   C3   D3   0.350V   0ns   NA   NA
   F7   G7   0.350V   0ns   NA   NA
|   Model Selector
[Model Selector] I/O
DQ34_ODT0   34ohm IO model with no ODT
DQ34_ODT20   34ohm IO model with 20 Ohm ODT Submodel
DQ34_ODT30   34ohm IO model with 30 Ohm ODT Submodel
DQ34_ODT40   34ohm IO model with 40 Ohm ODT Submodel
DQ34_ODT60   34ohm IO model with 60 Ohm ODT Submodel
DQ34_ODT120   34ohm IO model with 120 Ohm ODT Submodel
DQ40_ODT0   40ohm IO model with no ODT
DQ40_ODT20   40ohm IO model with 20 Ohm ODT Submodel
DQ40_ODT30   40ohm IO model with 30 Ohm ODT Submodel
DQ40_ODT40   40ohm IO model with 40 Ohm ODT Submodel
DQ40_ODT60   40ohm IO model with 60 Ohm ODT Submodel
DQ40_ODT120   40ohm IO model with 120 Ohm ODT Submodel
[Model Selector] DM
DM_ODT0   DM input model with no ODT
DM_ODT20   DM Input model with 20 Ohm ODT Submodel
DM_ODT30   DM Input model with 30 Ohm ODT Submodel
DM_ODT40   DM Input model with 40 Ohm ODT Submodel
DM_ODT60   DM Input model with 60 Ohm ODT Submodel
DM_ODT120   DM Input model with 120 Ohm ODT Submodel
| Models and submodels in the file (25): DQ34_ODT0 (I/O), DQ34_ODT20 (I/O), DQ34_ODT30 (I/O), DQ34_ODT40 (I/O), DQ34_ODT60 (I/O), DQ34_ODT120 (I/O), DQ40_ODT0 (I/O), DQ40_ODT20 (I/O), DQ40_ODT30 (I/O), DQ40_ODT40 (I/O), DQ40_ODT60 (I/O), DQ40_ODT120 (I/O), DM_ODT0 (Input), DM_ODT20 (Input), DM_ODT30 (Input), DM_ODT40 (Input), DM_ODT60 (Input), DM_ODT120 (Input), RECEIVER (Input), CLKRCV (Input), ODT20ohm (Dynamic_clamp), ODT30ohm (Dynamic_clamp), ODT40ohm (Dynamic_clamp), ODT60ohm (Dynamic_clamp), ODT120ohm (Dynamic_clamp)
